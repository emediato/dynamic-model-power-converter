R1 2 1 1e-3
L1 2 3 470e-6
C1 3 0 10e-6
R2 3 4 10
L2 4 0 1e-3
V1 1 0 36
